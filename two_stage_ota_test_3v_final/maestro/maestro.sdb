ADE simulation setup
Run mode: Single Run, Sweeps and Corners
Tests:
  myDesign_two_stage_ota_test_3v_final_1: myDesign/two_stage_ota_test_3v_final/schematic, simulator spectre
    Variables: vsweep_ICMR = 0; vsweep_OVSR = 0
