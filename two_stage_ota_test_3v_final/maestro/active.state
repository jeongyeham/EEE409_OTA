ADE simulation setup
Test myDesign_two_stage_ota_test_3v_final_1: myDesign/two_stage_ota_test_3v_final/schematic, simulator spectre
  Models: /app/projects/te01_RFIC/TE01-TSMC_180nm_RF_v1.0a_1P6M/pdk/TSMC_180nm_RF_v1.0a_1P6M/tsmc18/../models/spectre/cr018gpii_v1d0.scs[tt_rfres_sa, tt_rfmvar, tt_rtmom, tt_disres, tt, tt_rfesd, tt_mim, tt_fmom, tt_rfres_rpo, tt_m, tt_rfmim, tt_res, tt_bip, tt_bip3, tt_dio3, tt_3v, tt_na, tt_dio, tt_dio_m, tt_rfind, tt_dio_3m, tt_bbmvar, tt_rfres_hri, tt_3vna, tt_dio_dnw, tt_3m, tt_rfjvar, tt_rfmos, tt_rfsbd, tt_rfmvar_33, tt_rfmos33, tt_rffmom, stat_noise]
  Variables: vsweep_ICMR = 0; vsweep_OVSR = 0
  Temperature: 27
  Analysis dc: (saves the operating point)
  Analysis ac: start=1 stop=1G
  Analysis stb: start=0.001 stop=1G probe=/IPRB0 stbProbeMode=single-ended
  Analysis pz: p=/net3 n=/gnd! iprobe=/V2 freq=1
  Output Loop Gain Phase = phaseDegUnwrapped(getData("loopGain" ?result "stb"))
  Output Loop Gain dB20 = db(mag(getData("loopGain" ?result "stb")))
  Output Poles = pzFrequencyAndRealFilter(getData("poles" ?result "pz")) (unticked)
  Output Zeros = pzFrequencyAndRealFilter(getData("zeros" ?result "pz")) (unticked)
  Output v /net3; ac dB20(V) = db(vfreq('ac "/net3"))
  Output v /net3; ac deg(V) = phaseDegUnwrapped(vfreq('ac "/net3"))
Run mode: Single Run, Sweeps and Corners
